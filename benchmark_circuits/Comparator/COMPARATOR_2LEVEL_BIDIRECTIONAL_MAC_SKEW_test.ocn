simulator( 'spectre )
design(	 "netlist")
resultsDir( "" )
modelFile(
    '("toplevel.scs" "top_tt")
)
desVar(	  "vd" 1m	)
desVar(	  "offset" 0	)
temp( 27 )
run()
selectResult( 'tran )
plot(getData("/dout") )
OUT = sample((VT("/OUTP") - VT("OUTM")) 2.3e-10 2.3e-10 "linear" 1e-11)
plot( OUT ?expr '( "OUT" ) )
VOFF = cross(OUT 0 1 "either" nil nil)
plot( VOFF ?expr '( "VOFF" ) )
One\'s\ Probability = (average(sample(v("/dout" ?result "tran") 4.5e-09 2e-06 "linear" 1e-08)) / 1.1)
plot( One\'s\ Probability ?expr '( "One's Probability" ) )
plot( ((VT("OUTP") - VT("OUTM")) / VAR("vd")) )
