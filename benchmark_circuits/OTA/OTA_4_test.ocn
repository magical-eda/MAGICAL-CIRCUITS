simulator( 'spectre )
design(	 "netlist")
resultsDir( "" )
modelFile(
    '("toplevel.scs" "top_tt")
)
analysis('stb ?start "1"  ?stop "10G"  ?probe "/I11/vinj"  )
analysis('dc ?saveOppoint t  )
analysis('ac ?start "1"  ?stop "10G"  )
desVar(	  "Cfb" 100f	)
envOption(
	'setTopLevelAsSubckt  t
	'analysisOrder  list("dc" "ac" "tran" "stb" "noise")
)
converge( 'ic "/OUT-" "0.55" )
converge( 'ic "/OUT+" "0.55" )
temp( 27 )
run()
Loop\ Gain\ Phase = phaseDegUnwrapped(getData("loopGain" ?result "stb"))
plot( Loop\ Gain\ Phase ?expr '( "Loop Gain Phase" ) )
Loop\ Gain\ dB20 = db(mag(getData("loopGain" ?result "stb")))
plot( Loop\ Gain\ dB20 ?expr '( "Loop Gain dB20" ) )
AC = db((vfreq('ac "/OUT+") - vfreq('ac "/OUT-")))
plot( AC ?expr '( "AC" ) )
CMRR = value((AC - db((vfreq('ac "/OUTCM+") - vfreq('ac "/OUTCM-")))) 1000)
plot( CMRR ?expr '( "CMRR" ) )
